* rc test
VIN n0 0 AC 1
R1 n0 n1 1k
C1 n1 0 159.155n
.ac dec 5 10 100k
.end
